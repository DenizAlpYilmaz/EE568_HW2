# Ansys Electronics Desktop project, version 2022.1
materials:
  vacuum: permittivity=1
  steel_1008: permeability{HUnit=A_per_meter BUnit=tesla curve (0, 0) (159.2, 0.2402) (318.3, 0.8654) (477.5, 1.1106) (636.6, 1.2458) (795.8, 1.331) (1591.5, 1.5) (3183.1, 1.6) (4774.6, 1.683) (6366.2, 1.741) (7957.7, 1.78) (15915.5, 1.905) (31831, 2.025) (47746.5, 2.085) (63662, 2.13) (79577.5, 2.165) (159155, 2.28) (318310, 2.485) (397887, 2.5851)} conductivity=2000000
  copper: permeability=0.999991 conductivity=58000000
  NdFe35: CoordinateSystemType=Cylindrical permittivity=1 permeability=1.0997785 conductivity=625000 magnetic_coercivity{Magnitude=-890000A_per_meter DirComp1=1 DirComp2=0 DirComp3=0} lande_g_factor=2
  NdFe36: CoordinateSystemType=Cylindrical permittivity=1 permeability=1.0997785 conductivity=625000 magnetic_coercivity{Magnitude=-890000A_per_meter DirComp1=-1 DirComp2=0 DirComp3=0} lande_g_factor=2
  Magfine - NdFeB 30: CoordinateSystemType=Cylindrical permeability{HUnit=A_per_meter BUnit=tesla curve (-874100, 0) (-437050, 0.581) (0, 1.162)} magnetic_coercivity{Magnitude=-874100A_per_meter DirComp1=1 DirComp2=0 DirComp3=0}
  Magfine - NdFeB 31: CoordinateSystemType=Cylindrical permeability{HUnit=A_per_meter BUnit=tesla curve (-874100, 0) (-437050, 0.581) (0, 1.162)} magnetic_coercivity{Magnitude=-874100A_per_meter DirComp1=-1 DirComp2=0 DirComp3=0}

design Maxwell2DDesign1 (Maxwell 2D, Transient, XY geometry, model units mm)
options: ModelDepth=100mm
variables:
  Rsh = 23mm
  Imax = 0A
  segment = 72
  turn_coil = 3
  freque = 50Hz
  St_ro = 55mm
  ratio = 0.6
  Ro_ro = ratio*St_ro
  magnet = 4mm
geometry:
  Stator [steel_1008] = user_primitive(RMxprt/SlotCore.dll, DiaGap=76mm, DiaYoke=110mm, Length=0mm, Skew=0deg, Slots=24, SlotType=2, Hs0=0.35mm, Hs01=0mm, Hs1=1mm, Hs2=4mm, Bs0=2.5mm, Bs1=7mm, Bs2=7mm, Rs=0mm, FilletType=0, HalfSlot=0, SegAngle=0deg, LenRegion=200mm, InfoCore=0)
  A1_positive [copper] = user_primitive(RMxprt/LapCoil.dll, DiaGap=76mm, DiaYoke=110mm, Length=0mm, Skew=0deg, Slots=24, SlotType=1, Hs0=0.35mm, Hs1=0.25mm, Hs2=1.5mm, Bs0=2.5mm, Bs1=7mm, Bs2=7mm, Rs=0mm, FilletType=0, Layers=1, CoilPitch=1, EndExt=0mm, SpanExt=0mm, BendAngle=0deg, SegAngle=0deg, LenRegion=200mm, InfoCoil=1)
  A1_positive.separate_bodies()
  A1_negative, C1_negative, C1_positive, B1_positive, B1_negative [copper] = A1_positive.duplicate_around_axis(axis=Z, angle=15deg, total=24)  # copies kept: 1..5
  [Stator, A1_positive, A1_negative, C1_negative, C1_positive, B1_positive, B1_negative].split(plane=ZX, keep=PositiveOnly)
  Rotor [steel_1008] = circle(normal=Z, centre=(0mm, 0mm, 0mm), radius=33mm)
  Circle2 = circle(normal=Z, centre=(0mm, 0mm, 0mm), radius=Rsh)
  Rotor.subtract(Circle2)
  Rotor.split(plane=ZX, keep=PositiveOnly)
  Band [vacuum] = polyline((0mm, 0mm, 0mm) (37.5mm, 0mm, 0mm))
  Band.sweep_around_axis(axis=Z, angle=90deg, segments=36)
  Band_in [vacuum] = polyline((0mm, 0mm, 0mm) (37.25mm, 0mm, 0mm))
  Band_in.sweep_around_axis(axis=Z, angle=90deg, segments=36)
  Band_out [vacuum] = polyline((0mm, 0mm, 0mm) (37.75mm, 0mm, 0mm))
  Band_out.sweep_around_axis(axis=Z, angle=90deg, segments=36)
  Region [vacuum] = polyline((0mm, 0mm, 0mm) (65mm, 0, 0mm))
  Region.sweep_around_axis(axis=Z, angle=90deg, segments=6)
  [Rotor, Stator].split(plane=YZ, keep=PositiveOnly)
  Polyline1 = polyline(z=0mm, xy in mm: (36.4, 0) (25.738687, 25.738687) (2.2288572e-15, 36.4), AngularArc from point 0 over 3 centre=(0mm, 0mm, 0mm) angle=90deg plane=XY)
  PMCore1 = user_primitive(RMxprt/PMCore.dll, DiaGap=74mm, DiaYoke=20mm, Length=0mm, Poles=22, PoleType=1, Embrace=0.7, ThickMag=4mm, WidthMag=45mm, Offset=0mm, Bridge=2mm, Rib=3mm, LenRegion=200mm, InfoCore=1)
  PMCore1_Separate8, PMCore1_Separate9, PMCore1_Separate10 [Magfine - NdFeB 31], PMCore1_Separate11, PMCore1_Separate12, PMCore1_Separate21 [Magfine - NdFeB 30] = PMCore1.separate_bodies()
  PMCore1.delete()
  PMCore1_Separate8.split(plane=YZ, keep=PositiveOnly)
motion:
  MotionSetup1: Band Move_Type=Rotate Coordinate_System=Global Axis=Z Is_Positive=true InitPos=0deg Angular_Velocity="(3000/11) rpm" Objects=Band
  Moving1: Moving Objects=[PMCore1_Separate21, PMCore1_Separate10, PMCore1_Separate11, PMCore1_Separate9, PMCore1_Separate12, PMCore1_Separate8, Rotor, Band_in, Polyline1]
boundaries and excitations:
  VectorPotential1: Vector Potential Edges=Region.edge(#55353, #55352, #55351, #55350, #55349, #55348, #55347) Value=0
  Independent1: Independent Edges=Region.edge(1 of 1)
  Dependent1: Dependent Edges=Region.edge(#55354) ReverseU Independent=Independent1 SameAsMaster=false
  A1_negative: Coil Objects=A1_negative Conductor_number=turn_coil Winding=PhaseA PolarityType=Negative
  A1_positive: Coil Objects=A1_positive Conductor_number=turn_coil Winding=PhaseA PolarityType=Positive
  B1_negative: Coil Objects=B1_negative Conductor_number=turn_coil Winding=PhaseB PolarityType=Negative
  B1_positive: Coil Objects=B1_positive Conductor_number=turn_coil Winding=PhaseB PolarityType=Positive
  C1_negative: Coil Objects=C1_negative Conductor_number=turn_coil Winding=PhaseC PolarityType=Negative
  C1_positive: Coil Objects=C1_positive Conductor_number=turn_coil Winding=PhaseC PolarityType=Positive
  PhaseA: Winding Group Type=Current IsSolid=false Current=Imax*sin(2*freque*pi*Time) ParallelBranchesNum=1
  PhaseB: Winding Group Type=Current IsSolid=false Current=Imax*sin(2*freque*pi*Time-4*pi/3) ParallelBranchesNum=1
  PhaseC: Winding Group Type=Current IsSolid=false Current=Imax*sin(2*freque*pi*Time-2*pi/3) ParallelBranchesNum=1
mesh:
  initial mesh: MeshMethod=AnsoftTAU
setups:
  Setup1: Transient NonlinearSolverResidual=0.0001 StopTime=2/freque TimeStep=1/freque/150 SaveFieldsType=Custom SweepRanges{0ns to 0.04ns step 0.00013333333ns} NumberSolveSteps=1 RangeStart=0s RangeEnd=0.1s InitialTimeStep=0.002s MinTimeStep=0.001s MaxTimeStep=0.003s TimeStepErrTolerance=0.0001
output variables:
  Vab = InducedVoltage(PhaseA)-InducedVoltage(PhaseB)
  Vbc = InducedVoltage(PhaseB)-InducedVoltage(PhaseC)
  Vca = InducedVoltage(PhaseC)-InducedVoltage(PhaseA)
field calculator expressions:
  BTang = Fundamental_Quantity(22) | Tangent | Dot
  Bradial = Fundamental_Quantity(22) | 2D_Normal | Dot
  B_airgap = Bradial
reports:
  Torque Plot 1: Moving1.Torque vs Time on Setup1 : Transient
  Winding Plot 1: InducedVoltage(PhaseA), InducedVoltage(PhaseB), InducedVoltage(PhaseC) vs Time on Setup1 : Transient
  Calculator Expressions Plot 3: B_airgap vs Distance on Setup1 : Transient [Time=4e+07ns]
  Output Variables Plot 1: Vab, Vbc, Vca vs Time on Setup1 : Transient
